* SPICE3 file created from IV_converter_LDS.ext - technology: sky130A

.subckt IV_converter_LDS GND VDD Vgate Vmid Iin_Vout Vbn
X0 Iin_Vout Vgate Vmid GND sky130_fd_pr__nfet_01v8 ad=0.6 pd=3.2 as=0.6 ps=3.2 w=1 l=4
X1 a_n60_n600# Vbn GND GND sky130_fd_pr__nfet_01v8 ad=1.8 pd=7.2 as=1.8 ps=7.2 w=3 l=0.5
X2 GND a_n60_n600# Iin_Vout VDD sky130_fd_pr__pfet_01v8 ad=1.8 pd=7.2 as=1.8 ps=7.2 w=3 l=0.5
X3 Vmid a_n60_n600# a_n60_n600# Vmid sky130_fd_pr__pfet_01v8 ad=1.8 pd=7.2 as=1.8 ps=7.2 w=3 l=0.5
.ends
