* NGSPICE file created from controller.ext - technology: sky130A

* Black-box entry subcircuit for sky130_fd_sc_hd__decap_8 abstract view
.subckt sky130_fd_sc_hd__decap_8 VGND VNB VPB VPWR
.ends

* Black-box entry subcircuit for sky130_fd_sc_hd__tapvpwrvgnd_1 abstract view
.subckt sky130_fd_sc_hd__tapvpwrvgnd_1 VGND VPWR
.ends

* Black-box entry subcircuit for sky130_fd_sc_hd__nand2_1 abstract view
.subckt sky130_fd_sc_hd__nand2_1 A B VGND VNB VPB VPWR Y
.ends

* Black-box entry subcircuit for sky130_ef_sc_hd__decap_12 abstract view
.subckt sky130_ef_sc_hd__decap_12 VPWR VGND VPB VNB
.ends

* Black-box entry subcircuit for sky130_fd_sc_hd__o2111a_1 abstract view
.subckt sky130_fd_sc_hd__o2111a_1 A1 A2 B1 C1 D1 VGND VNB VPB VPWR X
.ends

* Black-box entry subcircuit for sky130_fd_sc_hd__fill_1 abstract view
.subckt sky130_fd_sc_hd__fill_1 VGND VNB VPB VPWR
.ends

* Black-box entry subcircuit for sky130_fd_sc_hd__buf_2 abstract view
.subckt sky130_fd_sc_hd__buf_2 A VGND VNB VPB VPWR X
.ends

* Black-box entry subcircuit for sky130_fd_sc_hd__decap_6 abstract view
.subckt sky130_fd_sc_hd__decap_6 VGND VNB VPB VPWR
.ends

* Black-box entry subcircuit for sky130_fd_sc_hd__decap_3 abstract view
.subckt sky130_fd_sc_hd__decap_3 VGND VNB VPB VPWR
.ends

* Black-box entry subcircuit for sky130_fd_sc_hd__or3b_1 abstract view
.subckt sky130_fd_sc_hd__or3b_1 A B C_N VGND VNB VPB VPWR X
.ends

* Black-box entry subcircuit for sky130_fd_sc_hd__and3b_1 abstract view
.subckt sky130_fd_sc_hd__and3b_1 A_N B C VGND VNB VPB VPWR X
.ends

* Black-box entry subcircuit for sky130_fd_sc_hd__fill_2 abstract view
.subckt sky130_fd_sc_hd__fill_2 VGND VNB VPB VPWR
.ends

* Black-box entry subcircuit for sky130_fd_sc_hd__and2b_1 abstract view
.subckt sky130_fd_sc_hd__and2b_1 A_N B VGND VNB VPB VPWR X
.ends

* Black-box entry subcircuit for sky130_fd_sc_hd__decap_4 abstract view
.subckt sky130_fd_sc_hd__decap_4 VGND VNB VPB VPWR
.ends

* Black-box entry subcircuit for sky130_fd_sc_hd__o21a_1 abstract view
.subckt sky130_fd_sc_hd__o21a_1 A1 A2 B1 VGND VNB VPB VPWR X
.ends

* Black-box entry subcircuit for sky130_fd_sc_hd__or2_1 abstract view
.subckt sky130_fd_sc_hd__or2_1 A B VGND VNB VPB VPWR X
.ends

* Black-box entry subcircuit for sky130_fd_sc_hd__clkinvlp_4 abstract view
.subckt sky130_fd_sc_hd__clkinvlp_4 A VGND VNB VPB VPWR Y
.ends

* Black-box entry subcircuit for sky130_fd_sc_hd__dfxtp_1 abstract view
.subckt sky130_fd_sc_hd__dfxtp_1 CLK D VGND VNB VPB VPWR Q
.ends

* Black-box entry subcircuit for sky130_fd_sc_hd__o211a_1 abstract view
.subckt sky130_fd_sc_hd__o211a_1 A1 A2 B1 C1 VGND VNB VPB VPWR X
.ends

* Black-box entry subcircuit for sky130_fd_sc_hd__clkbuf_16 abstract view
.subckt sky130_fd_sc_hd__clkbuf_16 A VGND VNB VPB VPWR X
.ends

* Black-box entry subcircuit for sky130_fd_sc_hd__and3_1 abstract view
.subckt sky130_fd_sc_hd__and3_1 A B C VGND VNB VPB VPWR X
.ends

* Black-box entry subcircuit for sky130_fd_sc_hd__clkbuf_2 abstract view
.subckt sky130_fd_sc_hd__clkbuf_2 A VGND VNB VPB VPWR X
.ends

* Black-box entry subcircuit for sky130_fd_sc_hd__inv_2 abstract view
.subckt sky130_fd_sc_hd__inv_2 A VGND VNB VPB VPWR Y
.ends

* Black-box entry subcircuit for sky130_fd_sc_hd__buf_1 abstract view
.subckt sky130_fd_sc_hd__buf_1 A VGND VNB VPB VPWR X
.ends

* Black-box entry subcircuit for sky130_fd_sc_hd__a21o_1 abstract view
.subckt sky130_fd_sc_hd__a21o_1 A1 A2 B1 VGND VNB VPB VPWR X
.ends

* Black-box entry subcircuit for sky130_fd_sc_hd__a32o_1 abstract view
.subckt sky130_fd_sc_hd__a32o_1 A1 A2 A3 B1 B2 VGND VNB VPB VPWR X
.ends

* Black-box entry subcircuit for sky130_fd_sc_hd__nor2_2 abstract view
.subckt sky130_fd_sc_hd__nor2_2 A B VGND VNB VPB VPWR Y
.ends

* Black-box entry subcircuit for sky130_fd_sc_hd__a211o_1 abstract view
.subckt sky130_fd_sc_hd__a211o_1 A1 A2 B1 C1 VGND VNB VPB VPWR X
.ends

* Black-box entry subcircuit for sky130_fd_sc_hd__a21oi_1 abstract view
.subckt sky130_fd_sc_hd__a21oi_1 A1 A2 B1 VGND VNB VPB VPWR Y
.ends

* Black-box entry subcircuit for sky130_fd_sc_hd__nand4_1 abstract view
.subckt sky130_fd_sc_hd__nand4_1 A B C D VGND VNB VPB VPWR Y
.ends

* Black-box entry subcircuit for sky130_fd_sc_hd__o31a_1 abstract view
.subckt sky130_fd_sc_hd__o31a_1 A1 A2 A3 B1 VGND VNB VPB VPWR X
.ends

* Black-box entry subcircuit for sky130_fd_sc_hd__and4bb_1 abstract view
.subckt sky130_fd_sc_hd__and4bb_1 A_N B_N C D VGND VNB VPB VPWR X
.ends

* Black-box entry subcircuit for sky130_fd_sc_hd__nand3_1 abstract view
.subckt sky130_fd_sc_hd__nand3_1 A B C VGND VNB VPB VPWR Y
.ends

* Black-box entry subcircuit for sky130_fd_sc_hd__and2_1 abstract view
.subckt sky130_fd_sc_hd__and2_1 A B VGND VNB VPB VPWR X
.ends

* Black-box entry subcircuit for sky130_fd_sc_hd__nor3b_2 abstract view
.subckt sky130_fd_sc_hd__nor3b_2 A B C_N VGND VNB VPB VPWR Y
.ends

* Black-box entry subcircuit for sky130_fd_sc_hd__o41a_1 abstract view
.subckt sky130_fd_sc_hd__o41a_1 A1 A2 A3 A4 B1 VGND VNB VPB VPWR X
.ends

* Black-box entry subcircuit for sky130_fd_sc_hd__nand2_2 abstract view
.subckt sky130_fd_sc_hd__nand2_2 A B VGND VNB VPB VPWR Y
.ends

* Black-box entry subcircuit for sky130_fd_sc_hd__a31oi_1 abstract view
.subckt sky130_fd_sc_hd__a31oi_1 A1 A2 A3 B1 VGND VNB VPB VPWR Y
.ends

* Black-box entry subcircuit for sky130_fd_sc_hd__and2_2 abstract view
.subckt sky130_fd_sc_hd__and2_2 A B VGND VNB VPB VPWR X
.ends

* Black-box entry subcircuit for sky130_fd_sc_hd__dlygate4sd3_1 abstract view
.subckt sky130_fd_sc_hd__dlygate4sd3_1 A VGND VNB VPB VPWR X
.ends

* Black-box entry subcircuit for sky130_fd_sc_hd__or4b_4 abstract view
.subckt sky130_fd_sc_hd__or4b_4 A B C D_N VGND VNB VPB VPWR X
.ends

* Black-box entry subcircuit for sky130_fd_sc_hd__dfxtp_2 abstract view
.subckt sky130_fd_sc_hd__dfxtp_2 CLK D VGND VNB VPB VPWR Q
.ends

* Black-box entry subcircuit for sky130_fd_sc_hd__nor4b_1 abstract view
.subckt sky130_fd_sc_hd__nor4b_1 A B C D_N VGND VNB VPB VPWR Y
.ends

* Black-box entry subcircuit for sky130_fd_sc_hd__or4_1 abstract view
.subckt sky130_fd_sc_hd__or4_1 A B C D VGND VNB VPB VPWR X
.ends

.subckt controller GND VDD adc_out[0] adc_out[1] adc_out[2] adc_out[3] adc_out[4]
+ adc_out[5] adc_out[6] adc_out[7] clk comp comparator_clk dac_in[0] dac_in[1] dac_in[2]
+ dac_in[3] dac_in[4] dac_in[5] dac_in[6] dac_in[7] dac_in_n[0] dac_in_n[1] dac_in_n[2]
+ dac_in_n[3] dac_in_n[4] dac_in_n[5] dac_in_n[6] dac_in_n[7] rst_n
XFILLER_9_159 GND GND VDD VDD sky130_fd_sc_hd__decap_8
XTAP_TAPCELL_ROW_8_66 GND VDD sky130_fd_sc_hd__tapvpwrvgnd_1
X_131_ _069_ _030_ GND GND VDD VDD _033_ sky130_fd_sc_hd__nand2_1
XFILLER_0_57 VDD GND VDD GND sky130_ef_sc_hd__decap_12
X_114_ _047_ _048_ _064_ net31 net28 GND GND VDD VDD _070_ sky130_fd_sc_hd__o2111a_1
XFILLER_7_279 GND GND VDD VDD sky130_fd_sc_hd__fill_1
Xoutput20 net20 GND GND VDD VDD dac_in_n[0] sky130_fd_sc_hd__buf_2
XTAP_TAPCELL_ROW_2_35 GND VDD sky130_fd_sc_hd__tapvpwrvgnd_1
Xoutput7 net7 GND GND VDD VDD adc_out[4] sky130_fd_sc_hd__buf_2
XFILLER_3_57 GND GND VDD VDD sky130_fd_sc_hd__decap_6
XTAP_TAPCELL_ROW_8_67 GND VDD sky130_fd_sc_hd__tapvpwrvgnd_1
XPHY_EDGE_ROW_4_Left_14 GND GND VDD VDD sky130_fd_sc_hd__decap_3
X_130_ net1 _063_ _030_ GND GND VDD VDD _032_ sky130_fd_sc_hd__or3b_1
XFILLER_9_45 GND GND VDD VDD sky130_fd_sc_hd__decap_8
XFILLER_0_69 VDD GND VDD GND sky130_ef_sc_hd__decap_12
XFILLER_2_133 GND GND VDD VDD sky130_fd_sc_hd__fill_1
XFILLER_2_155 VDD GND VDD GND sky130_ef_sc_hd__decap_12
X_113_ count\[0\] net32 net28 GND GND VDD VDD _069_ sky130_fd_sc_hd__and3b_1
XFILLER_7_225 GND GND VDD VDD sky130_fd_sc_hd__decap_6
XPHY_EDGE_ROW_6_Right_6 GND GND VDD VDD sky130_fd_sc_hd__decap_3
Xoutput21 net21 GND GND VDD VDD dac_in_n[1] sky130_fd_sc_hd__buf_2
Xoutput10 net10 GND GND VDD VDD adc_out[7] sky130_fd_sc_hd__buf_2
XFILLER_0_253 VDD GND VDD GND sky130_ef_sc_hd__decap_12
XTAP_TAPCELL_ROW_2_36 GND VDD sky130_fd_sc_hd__tapvpwrvgnd_1
Xoutput8 net8 GND GND VDD VDD adc_out[5] sky130_fd_sc_hd__buf_2
XFILLER_5_6 VDD GND VDD GND sky130_ef_sc_hd__decap_12
XTAP_TAPCELL_ROW_8_68 GND VDD sky130_fd_sc_hd__tapvpwrvgnd_1
XFILLER_5_175 GND GND VDD VDD sky130_fd_sc_hd__fill_2
XFILLER_0_15 VDD GND VDD GND sky130_ef_sc_hd__decap_12
XFILLER_2_167 GND GND VDD VDD sky130_fd_sc_hd__decap_3
XFILLER_2_189 GND GND VDD VDD sky130_fd_sc_hd__decap_6
XFILLER_3_3 VDD GND VDD GND sky130_ef_sc_hd__decap_12
XFILLER_9_57 GND GND VDD VDD sky130_fd_sc_hd__decap_3
X_112_ net33 net31 GND GND VDD VDD _068_ sky130_fd_sc_hd__and2b_1
Xoutput11 net11 GND GND VDD VDD comparator_clk sky130_fd_sc_hd__buf_2
Xoutput22 net22 GND GND VDD VDD dac_in_n[2] sky130_fd_sc_hd__buf_2
Xoutput9 net9 GND GND VDD VDD adc_out[6] sky130_fd_sc_hd__buf_2
XFILLER_0_265 GND GND VDD VDD sky130_fd_sc_hd__decap_8
XFILLER_0_221 GND GND VDD VDD sky130_fd_sc_hd__decap_3
XTAP_TAPCELL_ROW_2_37 GND VDD sky130_fd_sc_hd__tapvpwrvgnd_1
XFILLER_8_195 GND GND VDD VDD sky130_fd_sc_hd__fill_1
XFILLER_3_15 VDD GND VDD GND sky130_ef_sc_hd__decap_12
XTAP_TAPCELL_ROW_8_69 GND VDD sky130_fd_sc_hd__tapvpwrvgnd_1
XFILLER_5_143 GND GND VDD VDD sky130_fd_sc_hd__decap_4
XFILLER_4_91 VDD GND VDD GND sky130_ef_sc_hd__decap_12
XFILLER_0_27 GND GND VDD VDD sky130_fd_sc_hd__fill_1
X_111_ net30 _065_ net12 GND GND VDD VDD _067_ sky130_fd_sc_hd__o21a_1
XFILLER_1_92 VDD GND VDD GND sky130_ef_sc_hd__decap_12
XFILLER_6_15 VDD GND VDD GND sky130_ef_sc_hd__decap_12
Xoutput23 net23 GND GND VDD VDD dac_in_n[3] sky130_fd_sc_hd__buf_2
Xoutput12 net12 GND GND VDD VDD dac_in[0] sky130_fd_sc_hd__buf_2
XTAP_TAPCELL_ROW_2_38 GND VDD sky130_fd_sc_hd__tapvpwrvgnd_1
XFILLER_3_27 VDD GND VDD GND sky130_ef_sc_hd__decap_12
XFILLER_9_26 GND GND VDD VDD sky130_fd_sc_hd__fill_2
XPHY_EDGE_ROW_8_Left_18 GND GND VDD VDD sky130_fd_sc_hd__decap_3
X_110_ net30 _065_ GND GND VDD VDD _066_ sky130_fd_sc_hd__or2_1
Xclkload0 clknet_1_0__leaf_clk GND GND VDD VDD clkload0/Y sky130_fd_sc_hd__clkinvlp_4
XFILLER_4_209 VDD GND VDD GND sky130_ef_sc_hd__decap_12
XFILLER_6_27 GND GND VDD VDD sky130_fd_sc_hd__fill_1
Xoutput24 net24 GND GND VDD VDD dac_in_n[4] sky130_fd_sc_hd__buf_2
Xoutput13 net13 GND GND VDD VDD dac_in[1] sky130_fd_sc_hd__buf_2
XTAP_TAPCELL_ROW_2_39 GND VDD sky130_fd_sc_hd__tapvpwrvgnd_1
XFILLER_3_39 VDD GND VDD GND sky130_ef_sc_hd__decap_12
XFILLER_8_153 GND GND VDD VDD sky130_fd_sc_hd__fill_1
XFILLER_0_29 VDD GND VDD GND sky130_ef_sc_hd__decap_12
XFILLER_9_281 GND GND VDD VDD sky130_fd_sc_hd__decap_3
XTAP_TAPCELL_ROW_9_70 GND VDD sky130_fd_sc_hd__tapvpwrvgnd_1
XFILLER_1_3 VDD GND VDD GND sky130_ef_sc_hd__decap_12
XFILLER_7_207 GND GND VDD VDD sky130_fd_sc_hd__fill_2
X_169_ clknet_1_0__leaf_clk _018_ GND GND VDD VDD count\[0\] sky130_fd_sc_hd__dfxtp_1
XFILLER_3_243 VDD GND VDD GND sky130_ef_sc_hd__decap_12
Xoutput25 net25 GND GND VDD VDD dac_in_n[5] sky130_fd_sc_hd__buf_2
Xoutput14 net14 GND GND VDD VDD dac_in[2] sky130_fd_sc_hd__buf_2
XFILLER_8_165 GND GND VDD VDD sky130_fd_sc_hd__fill_2
XFILLER_5_113 GND GND VDD VDD sky130_fd_sc_hd__decap_4
XFILLER_4_83 GND GND VDD VDD sky130_fd_sc_hd__fill_1
XFILLER_4_190 GND GND VDD VDD sky130_fd_sc_hd__decap_6
XTAP_TAPCELL_ROW_9_71 GND VDD sky130_fd_sc_hd__tapvpwrvgnd_1
X_099_ net40 net29 GND GND VDD VDD _057_ sky130_fd_sc_hd__or2_1
X_168_ clknet_1_0__leaf_clk _017_ GND GND VDD VDD net19 sky130_fd_sc_hd__dfxtp_1
XFILLER_6_285 GND GND VDD VDD sky130_fd_sc_hd__decap_3
XFILLER_1_73 GND GND VDD VDD sky130_fd_sc_hd__fill_2
XFILLER_1_51 GND GND VDD VDD sky130_fd_sc_hd__decap_4
XFILLER_3_233 GND GND VDD VDD sky130_fd_sc_hd__decap_4
XFILLER_3_255 VDD GND VDD GND sky130_ef_sc_hd__decap_12
XFILLER_6_29 VDD GND VDD GND sky130_ef_sc_hd__decap_12
Xoutput26 net26 GND GND VDD VDD dac_in_n[6] sky130_fd_sc_hd__buf_2
Xoutput15 net15 GND GND VDD VDD dac_in[3] sky130_fd_sc_hd__buf_2
XPHY_EDGE_ROW_1_Right_1 GND GND VDD VDD sky130_fd_sc_hd__decap_3
XFILLER_0_225 VDD GND VDD GND sky130_ef_sc_hd__decap_12
XTAP_TAPCELL_ROW_3_40 GND VDD sky130_fd_sc_hd__tapvpwrvgnd_1
XFILLER_5_147 GND GND VDD VDD sky130_fd_sc_hd__fill_1
XFILLER_5_169 GND GND VDD VDD sky130_fd_sc_hd__fill_1
XFILLER_9_29 VDD GND VDD GND sky130_ef_sc_hd__decap_12
XTAP_TAPCELL_ROW_9_72 GND VDD sky130_fd_sc_hd__tapvpwrvgnd_1
X_167_ clknet_1_0__leaf_clk _016_ GND GND VDD VDD net18 sky130_fd_sc_hd__dfxtp_1
XFILLER_6_231 GND GND VDD VDD sky130_fd_sc_hd__decap_8
X_098_ net17 _050_ _056_ net34 GND GND VDD VDD _007_ sky130_fd_sc_hd__o211a_1
XFILLER_6_253 VDD GND VDD GND sky130_ef_sc_hd__decap_12
XFILLER_3_201 GND GND VDD VDD sky130_fd_sc_hd__fill_2
XFILLER_3_267 VDD GND VDD GND sky130_ef_sc_hd__decap_12
Xoutput27 net27 GND GND VDD VDD dac_in_n[7] sky130_fd_sc_hd__buf_2
Xoutput16 net16 GND GND VDD VDD dac_in[4] sky130_fd_sc_hd__buf_2
XFILLER_0_237 VDD GND VDD GND sky130_ef_sc_hd__decap_12
Xclkbuf_0_clk clk GND GND VDD VDD clknet_0_clk sky130_fd_sc_hd__clkbuf_16
XFILLER_8_145 GND GND VDD VDD sky130_fd_sc_hd__decap_8
XFILLER_8_123 GND GND VDD VDD sky130_fd_sc_hd__fill_1
XTAP_TAPCELL_ROW_3_41 GND VDD sky130_fd_sc_hd__tapvpwrvgnd_1
XFILLER_4_41 VDD GND VDD GND sky130_ef_sc_hd__decap_12
XTAP_TAPCELL_ROW_9_73 GND VDD sky130_fd_sc_hd__tapvpwrvgnd_1
XTAP_TAPCELL_ROW_0_20 GND VDD sky130_fd_sc_hd__tapvpwrvgnd_1
XFILLER_9_273 GND GND VDD VDD sky130_fd_sc_hd__decap_3
X_166_ clknet_1_1__leaf_clk _015_ GND GND VDD VDD net17 sky130_fd_sc_hd__dfxtp_1
X_097_ net41 net29 GND GND VDD VDD _056_ sky130_fd_sc_hd__or2_1
XFILLER_6_265 VDD GND VDD GND sky130_ef_sc_hd__decap_12
X_149_ _059_ _065_ _044_ GND GND VDD VDD _020_ sky130_fd_sc_hd__and3_1
XFILLER_3_279 GND GND VDD VDD sky130_fd_sc_hd__fill_1
Xoutput17 net17 GND GND VDD VDD dac_in[5] sky130_fd_sc_hd__buf_2
XFILLER_0_249 GND GND VDD VDD sky130_fd_sc_hd__decap_3
XFILLER_8_157 GND GND VDD VDD sky130_fd_sc_hd__decap_8
XTAP_TAPCELL_ROW_3_42 GND VDD sky130_fd_sc_hd__tapvpwrvgnd_1
XFILLER_2_119 GND GND VDD VDD sky130_fd_sc_hd__decap_4
XFILLER_4_53 VDD GND VDD GND sky130_ef_sc_hd__decap_12
XTAP_TAPCELL_ROW_0_21 GND VDD sky130_fd_sc_hd__tapvpwrvgnd_1
Xfanout30 count\[3\] GND GND VDD VDD net30 sky130_fd_sc_hd__clkbuf_2
XTAP_TAPCELL_ROW_9_74 GND VDD sky130_fd_sc_hd__tapvpwrvgnd_1
XPHY_EDGE_ROW_3_Left_13 GND GND VDD VDD sky130_fd_sc_hd__decap_3
X_165_ clknet_1_1__leaf_clk _014_ GND GND VDD VDD net16 sky130_fd_sc_hd__dfxtp_1
X_096_ net16 _050_ _055_ net34 GND GND VDD VDD _006_ sky130_fd_sc_hd__o211a_1
XFILLER_6_244 GND GND VDD VDD sky130_fd_sc_hd__decap_8
XFILLER_6_277 GND GND VDD VDD sky130_fd_sc_hd__decap_8
X_148_ _046_ _063_ GND GND VDD VDD _044_ sky130_fd_sc_hd__nand2_1
Xoutput18 net18 GND GND VDD VDD dac_in[6] sky130_fd_sc_hd__buf_2
X_079_ net14 GND GND VDD VDD net22 sky130_fd_sc_hd__inv_2
XPHY_EDGE_ROW_5_Right_5 GND GND VDD VDD sky130_fd_sc_hd__decap_3
XTAP_TAPCELL_ROW_3_43 GND VDD sky130_fd_sc_hd__tapvpwrvgnd_1
XFILLER_5_117 GND GND VDD VDD sky130_fd_sc_hd__fill_1
XFILLER_4_65 VDD GND VDD GND sky130_ef_sc_hd__decap_12
XFILLER_4_172 GND GND VDD VDD sky130_fd_sc_hd__decap_3
XTAP_TAPCELL_ROW_0_22 GND VDD sky130_fd_sc_hd__tapvpwrvgnd_1
Xfanout31 count\[1\] GND GND VDD VDD net31 sky130_fd_sc_hd__buf_2
XTAP_TAPCELL_ROW_9_75 GND VDD sky130_fd_sc_hd__tapvpwrvgnd_1
XFILLER_1_55 GND GND VDD VDD sky130_fd_sc_hd__fill_1
X_095_ net42 net29 GND GND VDD VDD _055_ sky130_fd_sc_hd__or2_1
X_164_ clknet_1_0__leaf_clk _013_ GND GND VDD VDD net15 sky130_fd_sc_hd__dfxtp_1
XFILLER_3_237 GND GND VDD VDD sky130_fd_sc_hd__fill_1
X_078_ net15 GND GND VDD VDD net23 sky130_fd_sc_hd__inv_2
X_147_ _059_ _063_ _043_ GND GND VDD VDD _019_ sky130_fd_sc_hd__and3_1
Xoutput19 net19 GND GND VDD VDD dac_in[7] sky130_fd_sc_hd__buf_2
XFILLER_8_115 GND GND VDD VDD sky130_fd_sc_hd__decap_8
XTAP_TAPCELL_ROW_3_44 GND VDD sky130_fd_sc_hd__tapvpwrvgnd_1
XFILLER_4_77 GND GND VDD VDD sky130_fd_sc_hd__decap_6
Xfanout32 count\[1\] GND GND VDD VDD net32 sky130_fd_sc_hd__buf_1
XFILLER_9_265 GND GND VDD VDD sky130_fd_sc_hd__decap_4
XTAP_TAPCELL_ROW_9_76 GND VDD sky130_fd_sc_hd__tapvpwrvgnd_1
XTAP_TAPCELL_ROW_0_23 GND VDD sky130_fd_sc_hd__tapvpwrvgnd_1
XFILLER_1_110 GND GND VDD VDD sky130_fd_sc_hd__fill_2
X_094_ net15 _050_ _054_ net34 GND GND VDD VDD _005_ sky130_fd_sc_hd__o211a_1
X_163_ clknet_1_0__leaf_clk _012_ GND GND VDD VDD net14 sky130_fd_sc_hd__dfxtp_1
X_077_ net16 GND GND VDD VDD net24 sky130_fd_sc_hd__inv_2
X_146_ net28 net33 net31 GND GND VDD VDD _043_ sky130_fd_sc_hd__a21o_1
XTAP_TAPCELL_ROW_6_55 GND VDD sky130_fd_sc_hd__tapvpwrvgnd_1
XFILLER_7_77 GND GND VDD VDD sky130_fd_sc_hd__fill_2
X_129_ _029_ _031_ _059_ GND GND VDD VDD _013_ sky130_fd_sc_hd__o21a_1
XFILLER_5_108 GND GND VDD VDD sky130_fd_sc_hd__decap_4
Xfanout33 count\[0\] GND GND VDD VDD net33 sky130_fd_sc_hd__buf_2
XTAP_TAPCELL_ROW_9_77 GND VDD sky130_fd_sc_hd__tapvpwrvgnd_1
XTAP_TAPCELL_ROW_0_24 GND VDD sky130_fd_sc_hd__tapvpwrvgnd_1
XFILLER_8_3 VDD GND VDD GND sky130_ef_sc_hd__decap_12
X_162_ clknet_1_1__leaf_clk _011_ GND GND VDD VDD net13 sky130_fd_sc_hd__dfxtp_1
X_093_ net43 _049_ GND GND VDD VDD _054_ sky130_fd_sc_hd__or2_1
Xinput1 comp GND GND VDD VDD net1 sky130_fd_sc_hd__buf_1
XPHY_EDGE_ROW_7_Left_17 GND GND VDD VDD sky130_fd_sc_hd__decap_3
X_076_ net17 GND GND VDD VDD net25 sky130_fd_sc_hd__inv_2
X_145_ _059_ _061_ _042_ GND GND VDD VDD _018_ sky130_fd_sc_hd__and3_1
XFILLER_2_261 VDD GND VDD GND sky130_ef_sc_hd__decap_12
XTAP_TAPCELL_ROW_6_56 GND VDD sky130_fd_sc_hd__tapvpwrvgnd_1
XFILLER_0_209 VDD GND VDD GND sky130_ef_sc_hd__decap_12
X_128_ _048_ _064_ _026_ _030_ _062_ GND GND VDD VDD _031_ sky130_fd_sc_hd__a32o_1
XPHY_EDGE_ROW_9_Right_9 GND GND VDD VDD sky130_fd_sc_hd__decap_3
XFILLER_7_183 VDD GND VDD GND sky130_ef_sc_hd__decap_12
XFILLER_4_164 GND GND VDD VDD sky130_fd_sc_hd__decap_8
XFILLER_4_197 VDD GND VDD GND sky130_ef_sc_hd__decap_12
XTAP_TAPCELL_ROW_9_78 GND VDD sky130_fd_sc_hd__tapvpwrvgnd_1
XTAP_TAPCELL_ROW_0_25 GND VDD sky130_fd_sc_hd__tapvpwrvgnd_1
XFILLER_1_167 GND GND VDD VDD sky130_fd_sc_hd__fill_1
Xfanout34 net2 GND GND VDD VDD net34 sky130_fd_sc_hd__buf_2
XFILLER_9_201 GND GND VDD VDD sky130_fd_sc_hd__decap_8
X_161_ clknet_1_0__leaf_clk _010_ GND GND VDD VDD net12 sky130_fd_sc_hd__dfxtp_1
X_092_ net14 _050_ _053_ net34 GND GND VDD VDD _004_ sky130_fd_sc_hd__o211a_1
Xinput2 rst_n GND GND VDD VDD net2 sky130_fd_sc_hd__buf_1
XFILLER_5_281 GND GND VDD VDD sky130_fd_sc_hd__decap_3
X_075_ net18 GND GND VDD VDD net26 sky130_fd_sc_hd__inv_2
X_144_ net28 net33 GND GND VDD VDD _042_ sky130_fd_sc_hd__or2_1
XFILLER_2_273 VDD GND VDD GND sky130_ef_sc_hd__decap_12
XTAP_TAPCELL_ROW_6_57 GND VDD sky130_fd_sc_hd__tapvpwrvgnd_1
XFILLER_2_90 GND GND VDD VDD sky130_fd_sc_hd__decap_4
X_127_ net30 count\[2\] GND GND VDD VDD _030_ sky130_fd_sc_hd__nor2_2
XFILLER_7_57 VDD GND VDD GND sky130_ef_sc_hd__decap_12
XFILLER_7_195 GND GND VDD VDD sky130_fd_sc_hd__decap_6
XTAP_TAPCELL_ROW_0_26 GND VDD sky130_fd_sc_hd__tapvpwrvgnd_1
XFILLER_1_113 VDD GND VDD GND sky130_ef_sc_hd__decap_12
XTAP_TAPCELL_ROW_9_79 GND VDD sky130_fd_sc_hd__tapvpwrvgnd_1
X_160_ clknet_1_1__leaf_clk net38 GND GND VDD VDD net10 sky130_fd_sc_hd__dfxtp_1
XFILLER_1_15 VDD GND VDD GND sky130_ef_sc_hd__decap_12
X_091_ net39 net29 GND GND VDD VDD _053_ sky130_fd_sc_hd__or2_1
X_143_ _048_ _039_ _041_ _060_ GND GND VDD VDD _017_ sky130_fd_sc_hd__a211o_1
XTAP_TAPCELL_ROW_6_58 GND VDD sky130_fd_sc_hd__tapvpwrvgnd_1
X_074_ net19 GND GND VDD VDD net27 sky130_fd_sc_hd__inv_2
XFILLER_2_285 GND GND VDD VDD sky130_fd_sc_hd__decap_3
XFILLER_7_69 GND GND VDD VDD sky130_fd_sc_hd__decap_8
X_126_ _064_ _026_ net23 GND GND VDD VDD _029_ sky130_fd_sc_hd__a21oi_1
XPHY_EDGE_ROW_0_Right_0 GND GND VDD VDD sky130_fd_sc_hd__decap_3
X_109_ net28 count\[2\] net31 net33 GND GND VDD VDD _065_ sky130_fd_sc_hd__nand4_1
XFILLER_4_15 VDD GND VDD GND sky130_ef_sc_hd__decap_12
XFILLER_4_155 GND GND VDD VDD sky130_fd_sc_hd__fill_1
XTAP_TAPCELL_ROW_0_27 GND VDD sky130_fd_sc_hd__tapvpwrvgnd_1
XFILLER_1_147 VDD GND VDD GND sky130_ef_sc_hd__decap_12
XFILLER_1_125 GND GND VDD VDD sky130_fd_sc_hd__decap_6
XFILLER_9_225 GND GND VDD VDD sky130_fd_sc_hd__decap_6
XFILLER_5_80 GND GND VDD VDD sky130_fd_sc_hd__fill_1
XFILLER_1_27 VDD GND VDD GND sky130_ef_sc_hd__decap_12
X_090_ net13 _050_ _052_ net34 GND GND VDD VDD _003_ sky130_fd_sc_hd__o211a_1
XFILLER_6_3 VDD GND VDD GND sky130_ef_sc_hd__decap_12
X_142_ _026_ _030_ net27 GND GND VDD VDD _041_ sky130_fd_sc_hd__a21oi_1
XTAP_TAPCELL_ROW_6_59 GND VDD sky130_fd_sc_hd__tapvpwrvgnd_1
X_073_ net33 GND GND VDD VDD _047_ sky130_fd_sc_hd__inv_2
X_125_ _025_ _027_ _028_ _059_ GND GND VDD VDD _012_ sky130_fd_sc_hd__o31a_1
XFILLER_7_15 VDD GND VDD GND sky130_ef_sc_hd__decap_12
X_108_ net30 count\[2\] GND GND VDD VDD _064_ sky130_fd_sc_hd__and2b_1
XFILLER_4_27 GND GND VDD VDD sky130_fd_sc_hd__fill_1
XFILLER_4_145 GND GND VDD VDD sky130_fd_sc_hd__decap_3
XFILLER_4_178 VDD GND VDD GND sky130_ef_sc_hd__decap_12
XFILLER_9_248 GND GND VDD VDD sky130_fd_sc_hd__decap_4
XTAP_TAPCELL_ROW_0_28 GND VDD sky130_fd_sc_hd__tapvpwrvgnd_1
XFILLER_1_159 GND GND VDD VDD sky130_fd_sc_hd__decap_8
XFILLER_0_181 GND GND VDD VDD sky130_fd_sc_hd__decap_6
XFILLER_1_39 VDD GND VDD GND sky130_ef_sc_hd__decap_12
XFILLER_5_251 VDD GND VDD GND sky130_ef_sc_hd__decap_12
X_072_ count\[2\] GND GND VDD VDD _046_ sky130_fd_sc_hd__inv_2
X_141_ _038_ _039_ _040_ _059_ GND GND VDD VDD _016_ sky130_fd_sc_hd__o31a_1
XFILLER_2_82 GND GND VDD VDD sky130_fd_sc_hd__fill_2
XFILLER_7_27 VDD GND VDD GND sky130_ef_sc_hd__decap_12
X_124_ net1 _068_ _022_ count\[2\] GND GND VDD VDD _028_ sky130_fd_sc_hd__and4bb_1
X_107_ net28 net31 net33 GND GND VDD VDD _063_ sky130_fd_sc_hd__nand3_1
XFILLER_7_110 GND GND VDD VDD sky130_fd_sc_hd__fill_2
XFILLER_7_121 GND GND VDD VDD sky130_fd_sc_hd__decap_6
XFILLER_7_154 GND GND VDD VDD sky130_fd_sc_hd__decap_4
XFILLER_8_81 GND GND VDD VDD sky130_fd_sc_hd__decap_3
XFILLER_4_124 VDD GND VDD GND sky130_ef_sc_hd__decap_12
XFILLER_9_216 GND GND VDD VDD sky130_fd_sc_hd__decap_8
XTAP_TAPCELL_ROW_0_29 GND VDD sky130_fd_sc_hd__tapvpwrvgnd_1
XFILLER_0_193 GND GND VDD VDD sky130_fd_sc_hd__decap_3
XFILLER_6_219 VDD GND VDD GND sky130_ef_sc_hd__decap_12
XFILLER_5_263 VDD GND VDD GND sky130_ef_sc_hd__decap_12
XPHY_EDGE_ROW_2_Left_12 GND GND VDD VDD sky130_fd_sc_hd__decap_3
XFILLER_2_244 GND GND VDD VDD sky130_fd_sc_hd__decap_8
X_140_ _046_ _068_ _022_ _048_ GND GND VDD VDD _040_ sky130_fd_sc_hd__o211a_1
XFILLER_2_61 GND GND VDD VDD sky130_fd_sc_hd__fill_2
XFILLER_2_94 GND GND VDD VDD sky130_fd_sc_hd__fill_1
XFILLER_7_39 GND GND VDD VDD sky130_fd_sc_hd__fill_1
XTAP_TAPCELL_ROW_7_60 GND VDD sky130_fd_sc_hd__tapvpwrvgnd_1
X_123_ _064_ _026_ GND GND VDD VDD _027_ sky130_fd_sc_hd__and2_1
XFILLER_7_100 GND GND VDD VDD sky130_fd_sc_hd__decap_3
X_106_ net28 net32 net33 GND GND VDD VDD _062_ sky130_fd_sc_hd__and3_1
XPHY_EDGE_ROW_4_Right_4 GND GND VDD VDD sky130_fd_sc_hd__decap_3
XFILLER_4_29 VDD GND VDD GND sky130_ef_sc_hd__decap_12
XFILLER_4_103 GND GND VDD VDD sky130_fd_sc_hd__decap_8
XFILLER_4_136 GND GND VDD VDD sky130_fd_sc_hd__decap_4
Xfanout28 net11 GND GND VDD VDD net28 sky130_fd_sc_hd__clkbuf_2
XFILLER_5_72 GND GND VDD VDD sky130_fd_sc_hd__fill_1
XFILLER_5_275 GND GND VDD VDD sky130_fd_sc_hd__decap_4
XFILLER_2_223 GND GND VDD VDD sky130_fd_sc_hd__decap_8
XFILLER_4_3 VDD GND VDD GND sky130_ef_sc_hd__decap_12
X_122_ net31 net33 net28 GND GND VDD VDD _026_ sky130_fd_sc_hd__nor3b_2
XTAP_TAPCELL_ROW_7_61 GND VDD sky130_fd_sc_hd__tapvpwrvgnd_1
X_105_ net28 count\[0\] GND GND VDD VDD _061_ sky130_fd_sc_hd__nand2_1
XFILLER_7_134 GND GND VDD VDD sky130_fd_sc_hd__fill_2
XFILLER_3_181 VDD GND VDD GND sky130_ef_sc_hd__decap_12
XTAP_TAPCELL_ROW_1_30 GND VDD sky130_fd_sc_hd__tapvpwrvgnd_1
XFILLER_5_221 GND GND VDD VDD sky130_fd_sc_hd__decap_3
XFILLER_2_41 VDD GND VDD GND sky130_ef_sc_hd__decap_12
X_121_ net30 _046_ net31 _061_ net14 GND GND VDD VDD _025_ sky130_fd_sc_hd__o41a_1
Xclkbuf_1_0__f_clk clknet_0_clk GND GND VDD VDD clknet_1_0__leaf_clk sky130_fd_sc_hd__clkbuf_16
XTAP_TAPCELL_ROW_7_62 GND VDD sky130_fd_sc_hd__tapvpwrvgnd_1
X_104_ net34 _050_ GND GND VDD VDD _060_ sky130_fd_sc_hd__nand2_2
XFILLER_7_113 GND GND VDD VDD sky130_fd_sc_hd__decap_3
XFILLER_3_193 GND GND VDD VDD sky130_fd_sc_hd__decap_8
XFILLER_0_141 VDD GND VDD GND sky130_ef_sc_hd__decap_12
XFILLER_5_30 GND GND VDD VDD sky130_fd_sc_hd__decap_8
XTAP_TAPCELL_ROW_1_31 GND VDD sky130_fd_sc_hd__tapvpwrvgnd_1
XFILLER_2_203 GND GND VDD VDD sky130_fd_sc_hd__fill_1
XFILLER_2_75 GND GND VDD VDD sky130_fd_sc_hd__fill_2
XFILLER_2_53 GND GND VDD VDD sky130_fd_sc_hd__decap_8
X_120_ _071_ _023_ _024_ _060_ GND GND VDD VDD _011_ sky130_fd_sc_hd__a31oi_1
XPHY_EDGE_ROW_6_Left_16 GND GND VDD VDD sky130_fd_sc_hd__decap_3
XTAP_TAPCELL_ROW_7_63 GND VDD sky130_fd_sc_hd__tapvpwrvgnd_1
X_103_ net34 _050_ GND GND VDD VDD _059_ sky130_fd_sc_hd__and2_2
XFILLER_7_158 GND GND VDD VDD sky130_fd_sc_hd__fill_1
XFILLER_7_169 GND GND VDD VDD sky130_fd_sc_hd__fill_2
XFILLER_6_180 VDD GND VDD GND sky130_ef_sc_hd__decap_12
XFILLER_8_41 VDD GND VDD GND sky130_ef_sc_hd__decap_12
XFILLER_8_85 VDD GND VDD GND sky130_ef_sc_hd__decap_12
XPHY_EDGE_ROW_8_Right_8 GND GND VDD VDD sky130_fd_sc_hd__decap_3
Xhold1 net11 GND GND VDD VDD net36 sky130_fd_sc_hd__dlygate4sd3_1
XFILLER_9_209 GND GND VDD VDD sky130_fd_sc_hd__decap_3
XFILLER_8_264 VDD GND VDD GND sky130_ef_sc_hd__decap_12
XFILLER_8_253 GND GND VDD VDD sky130_fd_sc_hd__decap_8
XFILLER_8_231 GND GND VDD VDD sky130_fd_sc_hd__fill_1
XFILLER_0_197 VDD GND VDD GND sky130_ef_sc_hd__decap_12
XFILLER_0_153 VDD GND VDD GND sky130_ef_sc_hd__decap_12
XTAP_TAPCELL_ROW_1_32 GND VDD sky130_fd_sc_hd__tapvpwrvgnd_1
XFILLER_1_281 GND GND VDD VDD sky130_fd_sc_hd__decap_3
XFILLER_2_3 VDD GND VDD GND sky130_ef_sc_hd__decap_12
XTAP_TAPCELL_ROW_7_64 GND VDD sky130_fd_sc_hd__tapvpwrvgnd_1
X_102_ net37 _050_ _058_ net2 GND GND VDD VDD _009_ sky130_fd_sc_hd__o211a_1
XFILLER_8_97 GND GND VDD VDD sky130_fd_sc_hd__fill_2
XFILLER_6_192 GND GND VDD VDD sky130_fd_sc_hd__decap_4
Xhold2 net19 GND GND VDD VDD net37 sky130_fd_sc_hd__dlygate4sd3_1
XFILLER_3_151 GND GND VDD VDD sky130_fd_sc_hd__decap_6
XFILLER_3_162 GND GND VDD VDD sky130_fd_sc_hd__decap_6
XFILLER_8_276 GND GND VDD VDD sky130_fd_sc_hd__decap_4
XFILLER_0_187 GND GND VDD VDD sky130_fd_sc_hd__fill_1
XFILLER_0_165 GND GND VDD VDD sky130_fd_sc_hd__decap_3
XTAP_TAPCELL_ROW_1_33 GND VDD sky130_fd_sc_hd__tapvpwrvgnd_1
XFILLER_5_279 GND GND VDD VDD sky130_fd_sc_hd__fill_1
Xmax_cap29 _049_ GND GND VDD VDD net29 sky130_fd_sc_hd__buf_1
XFILLER_9_190 GND GND VDD VDD sky130_fd_sc_hd__decap_6
X_101_ net10 _049_ GND GND VDD VDD _058_ sky130_fd_sc_hd__or2_1
XFILLER_6_160 GND GND VDD VDD sky130_fd_sc_hd__fill_2
Xhold3 _009_ GND GND VDD VDD net38 sky130_fd_sc_hd__dlygate4sd3_1
XFILLER_5_66 GND GND VDD VDD sky130_fd_sc_hd__decap_6
XFILLER_5_99 GND GND VDD VDD sky130_fd_sc_hd__decap_6
XTAP_TAPCELL_ROW_1_34 GND VDD sky130_fd_sc_hd__tapvpwrvgnd_1
XFILLER_5_225 GND GND VDD VDD sky130_fd_sc_hd__decap_6
X_100_ net18 _050_ _057_ net34 GND GND VDD VDD _008_ sky130_fd_sc_hd__o211a_1
Xhold4 net5 GND GND VDD VDD net39 sky130_fd_sc_hd__dlygate4sd3_1
XTAP_TAPCELL_ROW_4_45 GND VDD sky130_fd_sc_hd__tapvpwrvgnd_1
XFILLER_0_3 VDD GND VDD GND sky130_ef_sc_hd__decap_12
X_159_ clknet_1_1__leaf_clk _008_ GND GND VDD VDD net9 sky130_fd_sc_hd__dfxtp_1
XFILLER_3_132 GND GND VDD VDD sky130_fd_sc_hd__fill_2
XTAP_TAPCELL_ROW_4_46 GND VDD sky130_fd_sc_hd__tapvpwrvgnd_1
Xhold5 net9 GND GND VDD VDD net40 sky130_fd_sc_hd__dlygate4sd3_1
XFILLER_0_113 VDD GND VDD GND sky130_ef_sc_hd__decap_12
XFILLER_8_235 GND GND VDD VDD sky130_fd_sc_hd__fill_1
XFILLER_5_57 GND GND VDD VDD sky130_fd_sc_hd__decap_3
XFILLER_1_252 VDD GND VDD GND sky130_ef_sc_hd__decap_12
XFILLER_1_230 GND GND VDD VDD sky130_fd_sc_hd__decap_6
XPHY_EDGE_ROW_1_Left_11 GND GND VDD VDD sky130_fd_sc_hd__decap_3
X_089_ net4 _049_ GND GND VDD VDD _052_ sky130_fd_sc_hd__or2_1
XFILLER_6_152 GND GND VDD VDD sky130_fd_sc_hd__decap_8
X_158_ clknet_1_1__leaf_clk _007_ GND GND VDD VDD net8 sky130_fd_sc_hd__dfxtp_1
XTAP_TAPCELL_ROW_4_47 GND VDD sky130_fd_sc_hd__tapvpwrvgnd_1
XFILLER_3_111 GND GND VDD VDD sky130_fd_sc_hd__fill_1
Xhold6 net8 GND GND VDD VDD net41 sky130_fd_sc_hd__dlygate4sd3_1
XPHY_EDGE_ROW_3_Right_3 GND GND VDD VDD sky130_fd_sc_hd__decap_3
XFILLER_0_169 VDD GND VDD GND sky130_ef_sc_hd__decap_12
XFILLER_0_125 VDD GND VDD GND sky130_ef_sc_hd__decap_12
Xclkbuf_1_1__f_clk clknet_0_clk GND GND VDD VDD clknet_1_1__leaf_clk sky130_fd_sc_hd__clkbuf_16
XFILLER_5_239 VDD GND VDD GND sky130_ef_sc_hd__decap_12
XFILLER_4_261 VDD GND VDD GND sky130_ef_sc_hd__decap_12
XFILLER_2_15 VDD GND VDD GND sky130_ef_sc_hd__decap_12
XFILLER_1_264 VDD GND VDD GND sky130_ef_sc_hd__decap_12
X_088_ net12 _050_ _051_ net34 GND GND VDD VDD _002_ sky130_fd_sc_hd__o211a_1
X_157_ clknet_1_1__leaf_clk _006_ GND GND VDD VDD net7 sky130_fd_sc_hd__dfxtp_1
XFILLER_8_69 VDD GND VDD GND sky130_ef_sc_hd__decap_12
XTAP_TAPCELL_ROW_4_48 GND VDD sky130_fd_sc_hd__tapvpwrvgnd_1
Xhold7 net7 GND GND VDD VDD net42 sky130_fd_sc_hd__dlygate4sd3_1
XFILLER_0_81 GND GND VDD VDD sky130_fd_sc_hd__decap_3
XFILLER_0_137 GND GND VDD VDD sky130_fd_sc_hd__decap_3
XFILLER_7_281 GND GND VDD VDD sky130_fd_sc_hd__decap_3
XFILLER_4_273 VDD GND VDD GND sky130_ef_sc_hd__decap_12
XFILLER_2_27 GND GND VDD VDD sky130_fd_sc_hd__fill_1
XFILLER_1_276 GND GND VDD VDD sky130_fd_sc_hd__decap_4
XFILLER_9_173 GND GND VDD VDD sky130_fd_sc_hd__fill_1
X_087_ net3 net29 GND GND VDD VDD _051_ sky130_fd_sc_hd__or2_1
X_156_ clknet_1_1__leaf_clk _005_ GND GND VDD VDD net6 sky130_fd_sc_hd__dfxtp_1
XFILLER_8_15 VDD GND VDD GND sky130_ef_sc_hd__decap_12
XFILLER_3_102 GND GND VDD VDD sky130_fd_sc_hd__fill_1
XFILLER_3_113 VDD GND VDD GND sky130_ef_sc_hd__decap_12
Xhold8 net6 GND GND VDD VDD net43 sky130_fd_sc_hd__dlygate4sd3_1
XTAP_TAPCELL_ROW_4_49 GND VDD sky130_fd_sc_hd__tapvpwrvgnd_1
X_139_ _026_ _030_ GND GND VDD VDD _039_ sky130_fd_sc_hd__and2_1
XFILLER_8_227 GND GND VDD VDD sky130_fd_sc_hd__decap_4
XFILLER_5_38 GND GND VDD VDD sky130_fd_sc_hd__fill_2
XFILLER_4_285 GND GND VDD VDD sky130_fd_sc_hd__decap_3
XFILLER_9_141 VDD GND VDD GND sky130_ef_sc_hd__decap_12
X_172_ clknet_1_0__leaf_clk _021_ GND GND VDD VDD count\[3\] sky130_fd_sc_hd__dfxtp_1
XPHY_EDGE_ROW_5_Left_15 GND GND VDD VDD sky130_fd_sc_hd__decap_3
X_155_ clknet_1_1__leaf_clk _004_ GND GND VDD VDD net5 sky130_fd_sc_hd__dfxtp_1
X_086_ count\[2\] net32 net33 net30 GND GND VDD VDD _050_ sky130_fd_sc_hd__or4b_4
XFILLER_8_27 GND GND VDD VDD sky130_fd_sc_hd__fill_1
XFILLER_3_125 GND GND VDD VDD sky130_fd_sc_hd__fill_1
XFILLER_3_169 VDD GND VDD GND sky130_ef_sc_hd__decap_12
X_138_ count\[3\] count\[2\] net31 _061_ net18 GND GND VDD VDD _038_ sky130_fd_sc_hd__o41a_1
XPHY_EDGE_ROW_7_Right_7 GND GND VDD VDD sky130_fd_sc_hd__decap_3
XFILLER_1_201 GND GND VDD VDD sky130_fd_sc_hd__decap_6
XFILLER_2_29 VDD GND VDD GND sky130_ef_sc_hd__decap_12
X_171_ clknet_1_0__leaf_clk _020_ GND GND VDD VDD count\[2\] sky130_fd_sc_hd__dfxtp_2
XFILLER_9_153 GND GND VDD VDD sky130_fd_sc_hd__fill_2
X_154_ clknet_1_1__leaf_clk _003_ GND GND VDD VDD net4 sky130_fd_sc_hd__dfxtp_1
X_085_ count\[2\] net32 count\[0\] count\[3\] GND GND VDD VDD _049_ sky130_fd_sc_hd__nor4b_1
X_137_ _035_ _036_ _037_ _060_ GND GND VDD VDD _015_ sky130_fd_sc_hd__a31oi_1
XFILLER_5_18 VDD GND VDD GND sky130_ef_sc_hd__decap_12
XTAP_TAPCELL_ROW_5_50 GND VDD sky130_fd_sc_hd__tapvpwrvgnd_1
XFILLER_4_221 VDD GND VDD GND sky130_ef_sc_hd__decap_12
X_170_ clknet_1_0__leaf_clk _019_ GND GND VDD VDD count\[1\] sky130_fd_sc_hd__dfxtp_1
XFILLER_9_121 VDD GND VDD GND sky130_ef_sc_hd__decap_12
XFILLER_9_110 GND GND VDD VDD sky130_fd_sc_hd__fill_2
XFILLER_3_51 GND GND VDD VDD sky130_fd_sc_hd__decap_4
X_153_ clknet_1_1__leaf_clk _002_ GND GND VDD VDD net3 sky130_fd_sc_hd__dfxtp_1
XFILLER_6_168 VDD GND VDD GND sky130_ef_sc_hd__decap_12
X_084_ net36 net34 GND GND VDD VDD _001_ sky130_fd_sc_hd__and2b_1
XFILLER_8_29 VDD GND VDD GND sky130_ef_sc_hd__decap_12
X_136_ _048_ _069_ _030_ GND GND VDD VDD _037_ sky130_fd_sc_hd__nand3_1
XFILLER_9_83 GND GND VDD VDD sky130_fd_sc_hd__fill_1
XFILLER_0_85 VDD GND VDD GND sky130_ef_sc_hd__decap_12
XFILLER_0_41 VDD GND VDD GND sky130_ef_sc_hd__decap_12
X_119_ _048_ _064_ _069_ GND GND VDD VDD _024_ sky130_fd_sc_hd__nand3_1
XTAP_TAPCELL_ROW_5_51 GND VDD sky130_fd_sc_hd__tapvpwrvgnd_1
XFILLER_7_263 VDD GND VDD GND sky130_ef_sc_hd__decap_12
XFILLER_4_233 GND GND VDD VDD sky130_fd_sc_hd__decap_3
XFILLER_6_73 GND GND VDD VDD sky130_fd_sc_hd__fill_1
XFILLER_7_3 VDD GND VDD GND sky130_ef_sc_hd__decap_12
XFILLER_9_133 GND GND VDD VDD sky130_fd_sc_hd__decap_3
XFILLER_3_63 GND GND VDD VDD sky130_fd_sc_hd__fill_1
XFILLER_3_74 VDD GND VDD GND sky130_ef_sc_hd__decap_12
X_152_ net35 _001_ GND GND VDD VDD net11 sky130_fd_sc_hd__dfxtp_1
XPHY_EDGE_ROW_9_Left_19 GND GND VDD VDD sky130_fd_sc_hd__decap_3
XFILLER_0_97 VDD GND VDD GND sky130_ef_sc_hd__decap_12
XFILLER_0_53 GND GND VDD VDD sky130_fd_sc_hd__decap_3
X_135_ net30 count\[2\] net32 _061_ GND GND VDD VDD _036_ sky130_fd_sc_hd__or4_1
XFILLER_0_109 GND GND VDD VDD sky130_fd_sc_hd__decap_3
X_118_ net30 _046_ net31 _061_ GND GND VDD VDD _023_ sky130_fd_sc_hd__or4_1
XTAP_TAPCELL_ROW_5_52 GND VDD sky130_fd_sc_hd__tapvpwrvgnd_1
XFILLER_7_275 GND GND VDD VDD sky130_fd_sc_hd__decap_4
XFILLER_6_41 VDD GND VDD GND sky130_ef_sc_hd__decap_12
XFILLER_0_281 GND GND VDD VDD sky130_fd_sc_hd__decap_3
Xoutput3 net3 GND GND VDD VDD adc_out[0] sky130_fd_sc_hd__buf_2
XFILLER_9_178 VDD GND VDD GND sky130_ef_sc_hd__decap_12
XFILLER_9_167 GND GND VDD VDD sky130_fd_sc_hd__fill_1
XFILLER_3_86 VDD GND VDD GND sky130_ef_sc_hd__decap_12
X_151_ _066_ _045_ _060_ GND GND VDD VDD _021_ sky130_fd_sc_hd__a21oi_1
X_082_ net1 GND GND VDD VDD _048_ sky130_fd_sc_hd__inv_2
XFILLER_2_195 GND GND VDD VDD sky130_fd_sc_hd__fill_1
X_134_ _069_ _030_ net25 GND GND VDD VDD _035_ sky130_fd_sc_hd__a21o_1
XFILLER_9_85 VDD GND VDD GND sky130_ef_sc_hd__decap_12
XTAP_TAPCELL_ROW_5_53 GND VDD sky130_fd_sc_hd__tapvpwrvgnd_1
X_117_ net30 net31 net33 net28 GND GND VDD VDD _022_ sky130_fd_sc_hd__and4bb_1
XFILLER_6_53 VDD GND VDD GND sky130_ef_sc_hd__decap_12
Xoutput4 net4 GND GND VDD VDD adc_out[1] sky130_fd_sc_hd__buf_2
XFILLER_9_113 GND GND VDD VDD sky130_fd_sc_hd__decap_4
XFILLER_9_102 GND GND VDD VDD sky130_fd_sc_hd__decap_8
XFILLER_3_98 GND GND VDD VDD sky130_fd_sc_hd__decap_4
X_081_ net12 GND GND VDD VDD net20 sky130_fd_sc_hd__inv_2
XPHY_EDGE_ROW_0_Left_10 GND GND VDD VDD sky130_fd_sc_hd__decap_3
X_150_ net30 _065_ GND GND VDD VDD _045_ sky130_fd_sc_hd__nand2_1
XFILLER_6_116 VDD GND VDD GND sky130_ef_sc_hd__decap_12
X_133_ _032_ _033_ _034_ _060_ GND GND VDD VDD _014_ sky130_fd_sc_hd__a31oi_1
XFILLER_9_97 GND GND VDD VDD sky130_fd_sc_hd__fill_1
XFILLER_9_64 VDD GND VDD GND sky130_ef_sc_hd__decap_12
XFILLER_9_53 GND GND VDD VDD sky130_fd_sc_hd__decap_3
XTAP_TAPCELL_ROW_5_54 GND VDD sky130_fd_sc_hd__tapvpwrvgnd_1
X_116_ _064_ _069_ net21 GND GND VDD VDD _071_ sky130_fd_sc_hd__a21o_1
XFILLER_7_222 GND GND VDD VDD sky130_fd_sc_hd__fill_2
XPHY_EDGE_ROW_2_Right_2 GND GND VDD VDD sky130_fd_sc_hd__decap_3
XFILLER_6_65 GND GND VDD VDD sky130_fd_sc_hd__decap_8
Xoutput5 net5 GND GND VDD VDD adc_out[2] sky130_fd_sc_hd__buf_2
X_083__1 clknet_1_1__leaf_clk GND GND VDD VDD net35 sky130_fd_sc_hd__inv_2
XFILLER_9_169 GND GND VDD VDD sky130_fd_sc_hd__fill_1
XFILLER_3_55 GND GND VDD VDD sky130_fd_sc_hd__fill_1
X_080_ net13 GND GND VDD VDD net21 sky130_fd_sc_hd__inv_2
XFILLER_8_191 GND GND VDD VDD sky130_fd_sc_hd__fill_1
XFILLER_6_106 GND GND VDD VDD sky130_fd_sc_hd__fill_1
XFILLER_6_128 VDD GND VDD GND sky130_ef_sc_hd__decap_12
XTAP_TAPCELL_ROW_8_65 GND VDD sky130_fd_sc_hd__tapvpwrvgnd_1
XFILLER_2_175 GND GND VDD VDD sky130_fd_sc_hd__decap_6
XFILLER_2_197 GND GND VDD VDD sky130_fd_sc_hd__decap_6
X_132_ _062_ _030_ net24 GND GND VDD VDD _034_ sky130_fd_sc_hd__a21o_1
XFILLER_9_76 GND GND VDD VDD sky130_fd_sc_hd__decap_3
XFILLER_9_10 VDD GND VDD GND sky130_ef_sc_hd__decap_12
X_115_ _067_ _070_ _059_ GND GND VDD VDD _010_ sky130_fd_sc_hd__o21a_1
XFILLER_3_281 GND GND VDD VDD sky130_fd_sc_hd__decap_3
XFILLER_1_207 GND GND VDD VDD sky130_fd_sc_hd__fill_1
Xoutput6 net6 GND GND VDD VDD adc_out[3] sky130_fd_sc_hd__buf_2
XFILLER_0_273 GND GND VDD VDD sky130_fd_sc_hd__decap_3
.ends
