* SPICE3 file created from bias_gen.ext - technology: sky130A

.subckt bias_gen Vbp Vbn VDD GND
X0 VDD a_740_700# Vbp VDD sky130_fd_pr__pfet_01v8 ad=2.1 pd=7.4 as=2.1 ps=7.4 w=3 l=0.5
X1 a_n3260_n1500# a_n3260_n1500# a_n3220_n1640# GND sky130_fd_pr__nfet_01v8 ad=2.1 pd=7.4 as=2.1 ps=7.4 w=3 l=0.5
X2 Vbn Vbn GND GND sky130_fd_pr__nfet_01v8 ad=2.1 pd=7.4 as=2.1 ps=7.4 w=3 l=0.5
X3 VDD Vbp a_n3260_n1500# VDD sky130_fd_pr__pfet_01v8 ad=2.1 pd=7.4 as=2.1 ps=7.4 w=3 l=0.5
X4 a_n3260_n1500# a_n3260_n1500# a_n3220_n1640# GND sky130_fd_pr__nfet_01v8 ad=2.1 pd=7.4 as=2.1 ps=7.4 w=3 l=0.5
X5 Vbp Vbn GND GND sky130_fd_pr__nfet_01v8 ad=2.1 pd=7.4 as=2.1 ps=7.4 w=3 l=0.5
X6 a_n3260_n1500# a_n3260_n1500# a_n3220_n1640# GND sky130_fd_pr__nfet_01v8 ad=2.1 pd=7.4 as=2.1 ps=7.4 w=3 l=0.5
X7 VDD a_740_700# a_740_700# VDD sky130_fd_pr__pfet_01v8 ad=2.1 pd=7.4 as=2.1 ps=7.4 w=3 l=0.5
X8 a_n3260_n1500# a_n3260_n1500# a_n3220_n1640# GND sky130_fd_pr__nfet_01v8 ad=2.1 pd=7.4 as=2.1 ps=7.4 w=3 l=0.5
X9 a_n3260_n1500# a_n3260_n1500# a_n3220_n1640# GND sky130_fd_pr__nfet_01v8 ad=2.1 pd=7.4 as=2.1 ps=7.4 w=3 l=0.5
X10 a_740_700# a_n3260_n1500# GND GND sky130_fd_pr__nfet_01v8 ad=2.1 pd=7.4 as=2.1 ps=7.4 w=3 l=0.5
X11 a_n3260_n1500# a_n3260_n1500# a_n3220_n1640# GND sky130_fd_pr__nfet_01v8 ad=2.1 pd=7.4 as=2.1 ps=7.4 w=3 l=0.5
X12 a_n3260_n1500# a_n3260_n1500# a_n3220_n1640# GND sky130_fd_pr__nfet_01v8 ad=2.1 pd=7.4 as=2.1 ps=7.4 w=3 l=0.5
X13 a_n3260_n1500# a_n3260_n1500# a_n3220_n1640# GND sky130_fd_pr__nfet_01v8 ad=2.1 pd=7.4 as=2.1 ps=7.4 w=3 l=0.5
X14 a_n3260_n1500# a_n3260_n1500# a_n3220_n1640# GND sky130_fd_pr__nfet_01v8 ad=2.1 pd=7.4 as=2.1 ps=7.4 w=3 l=0.5
X15 VDD Vbp Vbn VDD sky130_fd_pr__pfet_01v8 ad=2.1 pd=7.4 as=2.1 ps=7.4 w=3 l=0.5
X16 a_n3260_n1500# a_n3260_n1500# a_n3220_n1640# GND sky130_fd_pr__nfet_01v8 ad=2.1 pd=7.4 as=2.1 ps=7.4 w=3 l=0.5
X17 GND Vbp GND GND sky130_fd_pr__nfet_01v8 ad=7 pd=21.4 as=20.3 ps=65 w=10 l=10
X18 a_n3220_n1640# GND GND sky130_fd_pr__res_high_po_0p35 l=9.16
.ends
