* SPICE3 file created from comparator_LDS.ext - technology: sky130A

.subckt comparator_LDS VDD Vin_p Vin_n phi2 Q GND Vbn phi1 Qbar
X0 VDD a_n960_460# a_n960_1180# VDD sky130_fd_pr__pfet_01v8 ad=1.8 pd=7.2 as=1.8 ps=7.2 w=3 l=0.5
X1 a_n960_1180# Vin_p a_n960_680# GND sky130_fd_pr__nfet_01v8 ad=1.8 pd=7.2 as=1.8 ps=7.2 w=3 l=0.5
X2 GND Vbn a_n960_680# GND sky130_fd_pr__nfet_01v8 ad=1.8 pd=7.2 as=1.8 ps=7.2 w=3 l=0.5
X3 Q phi2 GND GND sky130_fd_pr__nfet_01v8 ad=1.8 pd=7.2 as=1.8 ps=7.2 w=3 l=0.5
X4 VDD a_n960_1180# a_n960_460# VDD sky130_fd_pr__pfet_01v8 ad=1.8 pd=7.2 as=1.8 ps=7.2 w=3 l=0.5
X5 a_n960_1180# phi1 a_n960_460# VDD sky130_fd_pr__pfet_01v8 ad=1.8 pd=7.2 as=1.8 ps=7.2 w=3 l=0.5
X6 a_n960_460# phi2 Q VDD sky130_fd_pr__pfet_01v8 ad=1.8 pd=7.2 as=1.8 ps=7.2 w=3 l=0.5
X7 a_n960_1180# phi2 Qbar VDD sky130_fd_pr__pfet_01v8 ad=1.8 pd=7.2 as=1.8 ps=7.2 w=3 l=0.5
X8 Qbar Q GND GND sky130_fd_pr__nfet_01v8 ad=1.8 pd=7.2 as=1.8 ps=7.2 w=3 l=0.5
X9 a_n960_680# Vin_n a_n960_460# GND sky130_fd_pr__nfet_01v8 ad=1.8 pd=7.2 as=1.8 ps=7.2 w=3 l=0.5
X10 Q Qbar GND GND sky130_fd_pr__nfet_01v8 ad=1.8 pd=7.2 as=1.8 ps=7.2 w=3 l=0.5
X11 Qbar phi2 GND GND sky130_fd_pr__nfet_01v8 ad=1.8 pd=7.2 as=1.8 ps=7.2 w=3 l=0.5
.ends
