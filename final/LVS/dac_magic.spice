* SPICE3 file created from dac.ext - technology: sky130A

.subckt inverter VP VDD A Y GND
X0 Y A GND GND sky130_fd_pr__nfet_01v8 ad=2.1 pd=7.4 as=2.1 ps=7.4 w=3 l=0.5
X1 Y A VP VDD sky130_fd_pr__pfet_01v8 ad=2.1 pd=7.4 as=2.1 ps=7.4 w=3 l=0.5
.ends

.subckt daccell GND Iin Iprime Vgate D Isense Idump VDD
Xinverter_0 Vgate VDD D inverter_0/Y GND inverter
X0 Iprime Vgate Iin GND sky130_fd_pr__nfet_01v8 ad=2.1 pd=7.4 as=2.1 ps=7.4 w=3 l=0.5
X1 a_0_n380# D Isense GND sky130_fd_pr__nfet_01v8 ad=2.1 pd=7.4 as=2.1 ps=7.4 w=3 l=0.5
X2 a_0_n380# inverter_0/Y Idump GND sky130_fd_pr__nfet_01v8 ad=2.1 pd=7.4 as=2.1 ps=7.4 w=3 l=0.5
X3 Iin Vgate a_0_n380# GND sky130_fd_pr__nfet_01v8 ad=2.1 pd=7.4 as=2.1 ps=7.4 w=3 l=0.5
.ends

.subckt dacend GND Iin Vgate Idump
X0 Iin Vgate Idump GND sky130_fd_pr__nfet_01v8 ad=2.1 pd=7.4 as=2.1 ps=7.4 w=3 l=0.5
.ends

.subckt dac GND Iin Vg Isense Idump sb7 sb6 sb5 sb4 sb3 sb2 sb1 sb0 VDD
Xdaccell_0 GND Iin daccell_1/Iin Vg sb7 Isense Idump VDD daccell
Xdaccell_1 GND daccell_1/Iin daccell_2/Iin Vg sb6 Isense Idump VDD daccell
Xdaccell_2 GND daccell_2/Iin daccell_3/Iin Vg sb5 Isense Idump VDD daccell
Xdaccell_3 GND daccell_3/Iin daccell_4/Iin Vg sb4 Isense Idump VDD daccell
Xdaccell_4 GND daccell_4/Iin daccell_5/Iin Vg sb3 Isense Idump VDD daccell
Xdaccell_5 GND daccell_5/Iin daccell_6/Iin Vg sb2 Isense Idump VDD daccell
Xdaccell_6 GND daccell_6/Iin daccell_7/Iin Vg sb1 Isense Idump VDD daccell
Xdaccell_7 GND daccell_7/Iin dacend_0/Iin Vg sb0 Isense Idump VDD daccell
Xdacend_0 GND dacend_0/Iin Vg Idump dacend
.ends
