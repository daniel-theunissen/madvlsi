* SPICE3 file created from cascode_bias_LDS.ext - technology: sky130A

.subckt cascode_bias_LDS Vbp VDD Vc GND Vdssat
X0 Vdssat a_680_0# GND GND sky130_fd_pr__nfet_01v8 ad=2.1 pd=7.4 as=2.1 ps=7.4 w=3 l=0.5
X1 VDD Vbp Vc VDD sky130_fd_pr__pfet_01v8 ad=2.1 pd=7.4 as=2.1 ps=7.4 w=3 l=0.5
X2 a_1460_840# Vbp a_680_0# VDD sky130_fd_pr__pfet_01v8 ad=2.1 pd=7.4 as=2.1 ps=7.4 w=3 l=0.5
X3 Vdssat a_680_0# a_680_0# GND sky130_fd_pr__nfet_01v8 ad=2.1 pd=7.4 as=2.1 ps=7.4 w=3 l=0.5
X4 a_1460_840# Vbp a_720_600# VDD sky130_fd_pr__pfet_01v8 ad=2.1 pd=7.4 as=2.1 ps=7.4 w=3 l=0.5
X5 Vdssat Vc Vc GND sky130_fd_pr__nfet_01v8 ad=2.1 pd=7.4 as=2.1 ps=7.4 w=3 l=0.5
X6 VDD Vbp a_720_600# VDD sky130_fd_pr__pfet_01v8 ad=2.1 pd=7.4 as=2.1 ps=7.4 w=3 l=0.5
X7 Vdssat a_680_0# a_680_0# GND sky130_fd_pr__nfet_01v8 ad=2.1 pd=7.4 as=2.1 ps=7.4 w=3 l=0.5
.ends
