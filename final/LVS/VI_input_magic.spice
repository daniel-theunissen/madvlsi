* SPICE3 file created from VI_input.ext - technology: sky130A

.subckt VI_input GND VDD Vbn Vbp OP1 MIN1 OP2 MIN2 Iout_minus Iout_plus Vin_minus
+ Vin_plus
X0 dw_960_4620# dw_960_1820# GND sky130_fd_pr__res_xhigh_po_0p35 l=20.16
X1 dw_960_4620# Vbp VDD VDD sky130_fd_pr__pfet_01v8 ad=1.5 pd=7 as=1.5 ps=7 w=3 l=2
X2 MIN2 Vbn GND GND sky130_fd_pr__nfet_01v8 ad=3 pd=5 as=1.5 ps=7 w=3 l=0.5
X3 Iout_minus OP2 MIN2 GND sky130_fd_pr__nfet_01v8 ad=1.5 pd=7 as=3 ps=5 w=3 l=0.5
X4 VDD Vbp dw_960_1820# VDD sky130_fd_pr__pfet_01v8 ad=1.5 pd=7 as=1.5 ps=7 w=3 l=2
X5 MIN1 Vin_plus dw_960_4620# dw_960_4620# sky130_fd_pr__pfet_01v8 ad=2 pd=9 as=2 ps=9 w=4 l=0.5
X6 dw_960_4620# Vbp VDD VDD sky130_fd_pr__pfet_01v8 ad=1.5 pd=7 as=1.5 ps=7 w=3 l=2
X7 MIN1 Vbn GND GND sky130_fd_pr__nfet_01v8 ad=1.5 pd=7 as=1.5 ps=7 w=3 l=0.5
X8 MIN1 Vbn GND GND sky130_fd_pr__nfet_01v8 ad=1.5 pd=7 as=1.5 ps=7 w=3 l=0.5
X9 MIN2 Vbn GND GND sky130_fd_pr__nfet_01v8 ad=1.5 pd=7 as=1.5 ps=7 w=3 l=0.5
X10 VDD Vbp dw_960_1820# VDD sky130_fd_pr__pfet_01v8 ad=1.5 pd=7 as=1.5 ps=7 w=3 l=2
X11 Iout_plus OP1 MIN1 GND sky130_fd_pr__nfet_01v8 ad=1.5 pd=7 as=1.5 ps=7 w=3 l=0.5
X12 VDD Vbp dw_960_1820# VDD sky130_fd_pr__pfet_01v8 ad=1.5 pd=7 as=1.5 ps=7 w=3 l=2
X13 MIN2 Vin_minus dw_960_1820# dw_960_1820# sky130_fd_pr__pfet_01v8 ad=2 pd=9 as=2 ps=9 w=4 l=0.5
X14 dw_960_4620# Vbp VDD VDD sky130_fd_pr__pfet_01v8 ad=1.5 pd=7 as=1.5 ps=7 w=3 l=2
.ends
