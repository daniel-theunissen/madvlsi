* SPICE3 file created from cascoded_opamp.ext - technology: sky130A

.subckt cascoded_opamp Vbp Vout GND Vbn Vminus Vplus VDD Vcp
X0 a_0_n500# Vcp Vout VDD sky130_fd_pr__pfet_01v8 ad=2.1 pd=7.4 as=2.1 ps=7.4 w=3 l=0.5
X1 a_880_n1200# a_880_n1200# GND GND sky130_fd_pr__nfet_01v8 ad=2.1 pd=7.4 as=2.1 ps=7.4 w=3 l=0.5
X2 Vout a_880_n1200# GND GND sky130_fd_pr__nfet_01v8 ad=2.1 pd=7.4 as=2.1 ps=7.4 w=3 l=0.5
X3 a_0_100# Vplus a_0_n1100# GND sky130_fd_pr__nfet_01v8 ad=2.1 pd=7.4 as=2.1 ps=7.4 w=3 l=0.5
X4 VDD Vbp a_0_100# VDD sky130_fd_pr__pfet_01v8 ad=2.1 pd=7.4 as=2.1 ps=7.4 w=3 l=0.5
X5 a_0_n1100# Vbn GND GND sky130_fd_pr__nfet_01v8 ad=2.1 pd=7.4 as=2.1 ps=7.4 w=3 l=0.5
X6 VDD Vbp a_0_n500# VDD sky130_fd_pr__pfet_01v8 ad=2.1 pd=7.4 as=2.1 ps=7.4 w=3 l=0.5
X7 a_0_100# Vcp a_880_n1200# VDD sky130_fd_pr__pfet_01v8 ad=2.1 pd=7.4 as=2.1 ps=7.4 w=3 l=0.5
X8 a_0_n500# Vminus a_0_n1100# GND sky130_fd_pr__nfet_01v8 ad=2.1 pd=7.4 as=2.1 ps=7.4 w=3 l=0.5
.ends
